# This file contains the DUT register and memory definitions

#
# Lab 7 - Task 7, Step 2
# Populate each of the following register and memory specification.
#
register HOST_ID {
#  ToDo
  bytes 2;
  field REV {
    bits 8;
    access ro;
    reset 'h03;
  }
  field CHIP {
    bits 8;
    access ro;
    reset 'h5A;
  }
}

register LOCK {
#  ToDo
  bytes 2;
  field LOCK {
    bits 16;
    access w1c;
    reset 16'hffff;
  }
}

register R_ARRAY {
#  ToDo
  bytes 2;
  field H_REG {
    bits 16;
    access rw;
    reset 16'h0000;
  }
}

memory RAM {
#  ToDo
  size 4k;
  bits 16;
  access rw;
}

#
#
# The block level declaration is done for you.  This include the hdl_path name for
# the signals in the DUT.  Later on, the hdl_path will be in RAL backdoor access.
#
block host_regmodel {
  bytes 2;
  register HOST_ID        (host_id)       @'h0000; # RTL path is only need for actual instances
  register LOCK           (lock)          @'h0100;
  register R_ARRAY[256]   (host_reg[%d])  @'h1000; # array must specify HDL index
  memory   RAM            (ram)           @'h4000;
}
